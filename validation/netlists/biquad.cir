Four-op-amp biquad high-pass filter
* A summer, two integrators and an output stage; nine resistors, two capacitors.
* Corner frequency about 5.1 kHz, quality factor 1, unity gain in the pass band.
.include opamp.lib
Vin in 0 dc 0 ac 1 pulse(0 5 10u 1u 1u 10u 1)
R1 in s 10k
R2 lp s 10k
R3 hp s 10k
R4 bp q 20k
R5 q 0 10k
R6 hp i1 6.2k
R7 bp i2 6.2k
R8 hp g 10k
R9 g out 10k
C1 i1 bp 5n
C2 i2 lp 5n
XU1 q s hp opamp aol=200000.0 gbw=10000000.0
XU2 0 i1 bp opamp aol=200000.0 gbw=10000000.0
XU3 0 i2 lp opamp aol=200000.0 gbw=10000000.0
XU4 0 g out opamp aol=200000.0 gbw=10000000.0
.end
