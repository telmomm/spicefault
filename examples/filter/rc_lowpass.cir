RC low-pass with a resistive load
* 10 kOhm source resistance, 100 nF, 10 kOhm load: 0.5 V/V at DC, corner at 318 Hz
V1 in 0 dc 1 ac 1 pulse(0 1 1m 1u 1u 5m 20m)
R1 in out 10k
C1 out 0 100n
R2 out 0 10k
.end
